* CircuitGate in-house signal-diode model card (typical published values, not vendor data).
* Authored for CircuitGate; redistribution permitted with the application.
.model d1n4148 d(is=2.52e-9 rs=0.568 n=1.752 cjo=4e-12 tt=11.54e-9)
