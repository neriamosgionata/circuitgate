* CircuitGate in-house 5.1 V zener model card (typical published values, not vendor data).
* Authored for CircuitGate; redistribution permitted with the application.
.model d1n4733 d(is=1e-14 rs=1.5 n=1.2 bv=5.1 ibv=0.02)
