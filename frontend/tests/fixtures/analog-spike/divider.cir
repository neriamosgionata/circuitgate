* CircuitGate analog spike: resistive divider, 12 V across equal 10k
V1 1 0 DC 12
R1 1 2 10k
R2 2 0 10k
.op
.end
