* CircuitGate analog spike: RC low-pass, fc = 1/(2*pi*1k*100n) = 1591.55 Hz
V1 1 0 DC 0 AC 1
R1 1 2 1k
C1 2 0 100n
.ac dec 20 10 1meg
.end
